ADE simulation setup
Run mode: Monte Carlo Sampling
Tests:
  assignment_1:Exercises_1:1: assignment_1/Exercises_1/schematic, simulator spectre
Global variables:
  R0 = 250.3k
Monte Carlo Sampling options: mcmethod=all, mcnumpoints=100
