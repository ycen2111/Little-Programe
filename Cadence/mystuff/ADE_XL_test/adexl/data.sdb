ADE simulation setup
Run mode: Monte Carlo Sampling
Tests:
  mystuff:res_load:1 (off): mystuff/res_load/schematic, simulator spectre
    Outputs: Gain; Vin
  mystuff:sweep_vds:1: mystuff/sweep_vds/schematic, simulator spectre
    Outputs: value(IS("/MN0/D") 2.5)
Global variables:
  vds = 5
  vgs = 5
Specs:
  mystuff:res_load:1 / Gain: > 60
Monte Carlo Sampling options: mcmethod=mismatch, mcnumpoints=100
