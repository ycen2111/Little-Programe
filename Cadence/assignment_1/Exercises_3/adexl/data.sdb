ADE simulation setup
Run mode: Single Run, Sweeps and Corners
Tests:
  assignment_1:Exercises_3:1: assignment_1/Exercises_3/schematic, simulator spectre
Global variables:
  f = 1k
  bias = 1.65
  r = {Exclusion List}240.5k{Exclusion List}{From/To}Auto:10k:20:500k{From/To}
Specs:
  assignment_1:Exercises_3:1 / tran gain: range 1.95 to 2.05
